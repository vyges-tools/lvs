* Layout with a real analog LVS error: the delta-Vbe sense resistor R_d is
* mis-wired — its far end lands on VREF instead of the a3 (VZ) branch node.
* In the schematic, R_d and R_z meet at the private node a3 and combine in
* series; here the miswire leaves a3 with only R_z, so the bug's resistors do
* NOT combine — the error surfaces as a resistor-count divergence. Must MISMATCH.
.subckt bandgap VDD VSS VREF
C_f  VREF VSS cap
Mpa  a1  g   VDD VDD pfet
Mpc  g   g   VDD VDD pfet
R_x  a1  VREF res
Q_a  a1  b   VSS npn
R_d  a2  VREF res
Mpb  a2  g   VDD VDD pfet
Q_b  a2  b   VSS npn
R_z  a3  VREF res
.ends
